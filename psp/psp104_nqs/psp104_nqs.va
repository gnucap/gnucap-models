//======================================================================================
//======================================================================================
// Filename: psp104_nqs.va
//======================================================================================
//======================================================================================
//
//  (c) Copyright notice
//
//  Since 2015 until today, PSP has been co-developed by NXP Semiconductors and
//  CEA-Leti. For this part of the model, each claim undivided ownership and copyrights
//  Since 2012 until 2015, PSP has been co-developed by NXP Semiconductors and
//  Delft University of Technology. For this part of the model, each claim undivided
//  ownership and copyrights
//  Until and including 2011, PSP has been co-developed by NXP Semiconductors and
//  Arizona State University. For this part of the model, NXP Semiconductors claims
//  undivided ownership and copyrights.
//
//
//  Version: 104.0.1 (PSP), 200.6.3 (JUNCAP), October 2024
//
//======================================================================================
//======================================================================================
//
// Further information can be found in the file releasenotesPSP104.txt
//

`include "discipline.h"

`define NQSmodel true

`include "Common104_macrodefs.include"

`include "JUNCAP200_macrodefs.include"

`include "JUNCAP200_InitModel.include"

`include "PSP104_macrodefs.include"

`include "PSP104_opvar.include"

/////////////////////////////////////////////////////////////////////////////
//
//  PSP global model code
//
/////////////////////////////////////////////////////////////////////////////

`include "PSP104_nqs_macrodefs.include"

module PSPNQS104VA(d, g, s, b);

`include "PSP104_module.include"

endmodule
